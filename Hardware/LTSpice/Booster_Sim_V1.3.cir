* KiCad schematic converted to LTspice - No-Loop High-Speed Edition
.title SYNCHRO Booster Simulation - 100% Schema-Konform (Stabil)

* ==========================================
* 1. SIMULATIONS-EINSTELLUNGEN
* ==========================================
.tran 100m

* ==========================================
* 2. BAUELEMENTE-MODELLE
* ==========================================
.model D_1N4148 D(Is=2.52n Rs=.568 N=1.752 Cjo=4p M=.4 vj=.5 tt=20n Ikf=25m Eg=1.11 Xti=3 Kf=0 Af=1 Fc=.5 BV=100 IBV=100u Tnom=25)
.model LED D(Is=2n Rs=5 N=2 Cjo=20p tt=50n BV=5 IBV=10u)

* Ein realer Schalter (Vt = 0.2V Schwellenspannung)
.model ShieldSwitch sw(Ron=10m Roff=10Meg Vt=0.2)
.model LoadSwitch sw(Ron=1 Roff=10Meg Vt=2.5)

* ==========================================
* 3. DEINE ORIGINAL-NETZLISTE (1:1 ÜBERNOMMEN)
* ==========================================
C10 +5V GND1 100n
R5 +5V Net-_U1-1OUT_ 4.7k
C2 +15V GND1 470u
C3 +15V GND1 470u

* Dein originaler Sense-Filter & Shunt
R2 /SENSE Net-_IC1-SENSE_ 1k
C1 /SENSE GND1 100n
R1 Net-_IC1-SENSE_ GND1 100m

R11 Net-_R11-Pad1_ GND1 10k
D5 /ENABLE Net-_D5-A_ LED
R13 +5V Net-_D5-A_ 1k
C4 GND1 Net-_IC1-VREF_ 10n
R9 +5V /Booster_Signal_B 4.7k
R10 +5V /Booster_Signal_A 4.7k
R12 +5V Net-_D4-A_ 1k
D4 GND1 Net-_D4-A_ LED
R8 /DCC_Signal_B Net-_D2-K_ 1.2k
D2 Net-_D2-K_ GND_Z D_1N4148
C12 +5V GND1 100n
C5 Net-_IC1-CBOOT1_ Net-_D3-A1_ 22n
C6 Net-_D3-A2_ Net-_IC1-CBOOT2_ 22n
C7 Net-_D3-A1_ Net-_C7-Pad2_ 22n
R6 Net-_C7-Pad2_ Net-_D3-A2_ 10
C8 +15V GND1 10u
C9 +5V GND1 100n
R3 +5V Net-_U1-1IN-_ 24k
R4 Net-_U1-1IN-_ GND1 1k
R7 /DCC_Signal_A Net-_D1-K_ 1.2k
D1 Net-_D1-K_ GND_Z D_1N4148
C11 +5V GND1 100n

* ==========================================
* 4. HARDWARE-TREIBER & LAST (STABIL)
* ==========================================
* Reale Grundlast im Normalbetrieb (zieht ca. 1.5A aus +15V)
R_Normal_Load +15V Net-_IC1-SENSE_ 10

* Kurzschluss-Pfad: Schaltet ab 20ms über einen niederohmigen Widerstand (1 Ohm) parallel
S_ShortCircuit +15V Net-_IC1-SENSE_ Net_Fault_Ctrl GND1 LoadSwitch
V_Fault_Pulse Net_Fault_Ctrl GND1 PULSE(0 5 20m 10u 10u 30m 100m)

* Interne Freilaufdiode des ICs am Shunt gegen GND1
D_internal_clamp GND1 Net-_IC1-SENSE_ D_1N4148

* ==========================================
* 5. AUTOMATISCHE SCHUTZ-ABSCHALTUNG (SCHALTER)
* ==========================================
* Wenn am gefilterten /SENSE-Pin mehr als 0.2V anliegen, wird /ENABLE nach GND geschlossen
S_Comp_Trigger /ENABLE GND1 /SENSE GND1 ShieldSwitch

.end
